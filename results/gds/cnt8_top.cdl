*
*  /home/eda/OpenLane/designs/project_scl_cp8d/smoke/5_klayout/lvs_drc/cnt8_top.cdl : SPICE netlist for KLayout LVS translated from: /home/eda/OpenLane/designs/project_scl_cp8d/smoke/runs/RUN/results/routing/cnt8_rt_pwr.v
*  Generated on 2026-10-03 18:59:14.068101
*
.INCLUDE core_iolib_cp8d.cdl

.SUBCKT CNT8_TOP GROUND VDD GROUND VDD CLK RST_N COUNT[0] COUNT[1] COUNT[2] COUNT[3] COUNT[4] COUNT[5] COUNT[6] COUNT[7]

XFILLER0_0_0 GROUND VDD FILLER4
XFILLER0_0_123 GROUND VDD FILLER2
XFILLER0_0_139 GROUND VDD FILLER3
XFILLER0_0_147 GROUND VDD FILLER4
XFILLER0_0_151 GROUND VDD FILLER5
XFILLER0_0_24 GROUND VDD FILLER4
XFILLER0_0_37 GROUND VDD FILLER3
XFILLER0_0_4 GROUND VDD FILLER5
XFILLER0_0_45 GROUND VDD FILLER4
XFILLER0_0_49 GROUND VDD FILLER5
XFILLER0_0_57 GROUND VDD FILLER3
XFILLER0_0_69 GROUND VDD FILLER5
XFILLER0_0_74 GROUND VDD FILLER3
XFILLER0_0_82 GROUND VDD FILLER5
XFILLER0_0_84 GROUND VDD FILLER6
XFILLER0_0_9 GROUND VDD FILLER3
XFILLER0_0_91 GROUND VDD FILLER1
XFILLER0_10_0 GROUND VDD FILLER3
XFILLER0_10_12 GROUND VDD FILLER5
XFILLER0_10_121 GROUND VDD FILLER1
XFILLER0_10_17 GROUND VDD FILLER6
XFILLER0_10_25 GROUND VDD FILLER1
XFILLER0_10_57 GROUND VDD FILLER1
XFILLER0_10_8 GROUND VDD FILLER4
XFILLER0_10_89 GROUND VDD FILLER1
XFILLER0_12_0 GROUND VDD FILLER1
XFILLER0_12_128 GROUND VDD FILLER2
XFILLER0_12_144 GROUND VDD FILLER3
XFILLER0_12_152 GROUND VDD FILLER6
XFILLER0_12_32 GROUND VDD FILLER1
XFILLER0_12_64 GROUND VDD FILLER1
XFILLER0_12_96 GROUND VDD FILLER1
XFILLER0_14_0 GROUND VDD FILLER1
XFILLER0_14_128 GROUND VDD FILLER2
XFILLER0_14_144 GROUND VDD FILLER3
XFILLER0_14_152 GROUND VDD FILLER6
XFILLER0_14_32 GROUND VDD FILLER1
XFILLER0_14_64 GROUND VDD FILLER1
XFILLER0_14_96 GROUND VDD FILLER1
XFILLER0_16_0 GROUND VDD FILLER1
XFILLER0_16_128 GROUND VDD FILLER2
XFILLER0_16_144 GROUND VDD FILLER3
XFILLER0_16_152 GROUND VDD FILLER6
XFILLER0_16_32 GROUND VDD FILLER1
XFILLER0_16_64 GROUND VDD FILLER1
XFILLER0_16_96 GROUND VDD FILLER1
XFILLER0_18_0 GROUND VDD FILLER1
XFILLER0_18_128 GROUND VDD FILLER2
XFILLER0_18_144 GROUND VDD FILLER3
XFILLER0_18_152 GROUND VDD FILLER6
XFILLER0_18_32 GROUND VDD FILLER1
XFILLER0_18_64 GROUND VDD FILLER1
XFILLER0_18_96 GROUND VDD FILLER1
XFILLER0_20_0 GROUND VDD FILLER1
XFILLER0_20_128 GROUND VDD FILLER2
XFILLER0_20_144 GROUND VDD FILLER3
XFILLER0_20_152 GROUND VDD FILLER6
XFILLER0_20_32 GROUND VDD FILLER1
XFILLER0_20_64 GROUND VDD FILLER1
XFILLER0_20_96 GROUND VDD FILLER1
XFILLER0_22_0 GROUND VDD FILLER1
XFILLER0_22_128 GROUND VDD FILLER2
XFILLER0_22_144 GROUND VDD FILLER3
XFILLER0_22_152 GROUND VDD FILLER6
XFILLER0_22_32 GROUND VDD FILLER1
XFILLER0_22_64 GROUND VDD FILLER1
XFILLER0_22_96 GROUND VDD FILLER1
XFILLER0_2_0 GROUND VDD FILLER3
XFILLER0_2_108 GROUND VDD FILLER1
XFILLER0_2_140 GROUND VDD FILLER3
XFILLER0_2_148 GROUND VDD FILLER4
XFILLER0_2_152 GROUND VDD FILLER6
XFILLER0_2_8 GROUND VDD FILLER6
XFILLER0_2_82 GROUND VDD FILLER5
XFILLER0_2_84 GROUND VDD FILLER6
XFILLER0_4_0 GROUND VDD FILLER2
XFILLER0_4_100 GROUND VDD FILLER1
XFILLER0_4_132 GROUND VDD FILLER2
XFILLER0_4_148 GROUND VDD FILLER4
XFILLER0_4_152 GROUND VDD FILLER6
XFILLER0_4_16 GROUND VDD FILLER4
XFILLER0_4_25 GROUND VDD FILLER2
XFILLER0_4_41 GROUND VDD FILLER4
XFILLER0_4_45 GROUND VDD FILLER5
XFILLER0_4_50 GROUND VDD FILLER3
XFILLER0_4_58 GROUND VDD FILLER4
XFILLER0_4_68 GROUND VDD FILLER1
XFILLER0_6_0 GROUND VDD FILLER3
XFILLER0_6_12 GROUND VDD FILLER5
XFILLER0_6_127 GROUND VDD FILLER2
XFILLER0_6_143 GROUND VDD FILLER3
XFILLER0_6_151 GROUND VDD FILLER5
XFILLER0_6_29 GROUND VDD FILLER2
XFILLER0_6_45 GROUND VDD FILLER4
XFILLER0_6_49 GROUND VDD FILLER6
XFILLER0_6_70 GROUND VDD FILLER3
XFILLER0_6_78 GROUND VDD FILLER6
XFILLER0_6_8 GROUND VDD FILLER4
XFILLER0_6_95 GROUND VDD FILLER1
XFILLER0_8_122 GROUND VDD FILLER2
XFILLER0_8_138 GROUND VDD FILLER3
XFILLER0_8_146 GROUND VDD FILLER4
XFILLER0_8_150 GROUND VDD FILLER5
XFILLER0_8_152 GROUND VDD FILLER6
XFILLER0_8_22 GROUND VDD FILLER6
XFILLER0_8_46 GROUND VDD FILLER5
XFILLER0_8_51 GROUND VDD FILLER4
XFILLER0_8_71 GROUND VDD FILLER3
XFILLER0_8_79 GROUND VDD FILLER4
XFILLER0_8_83 GROUND VDD FILLER6
XFILLER0_8_90 GROUND VDD FILLER1
X_30_ RST_N _08_ GROUND VDD INVR00
X_31_ COUNT_R[6] _09_ GROUND VDD INVR00
X_32_ RST_N _29_[0] _00_ GROUND VDD AND200
X_33_ RST_N COUNT_R[1] COUNT_R[0] _10_ GROUND VDD ORND00
X_34_ COUNT_R[1] COUNT_R[0] _10_ _01_ VDD GROUND ADNR00
X_35_ COUNT_R[2] COUNT_R[1] COUNT_R[0] _11_ GROUND VDD AND300
X_36_ COUNT_R[1] COUNT_R[0] COUNT_R[2] _12_ VDD GROUND ADNR00
X_37_ _08_ _11_ _12_ _02_ VDD GROUND NOR300
X_38_ COUNT_R[3] COUNT_R[2] COUNT_R[1] COUNT_R[0] _13_ GROUND VDD AND400
X_39_ RST_N _11_ COUNT_R[3] _14_ GROUND VDD ORND00
X_40_ _13_ _14_ _03_ VDD GROUND NOR200
X_41_ COUNT_R[4] COUNT_R[3] COUNT_R[2] COUNT_R[1] COUNT_R[0] _15_ GROUND VDD AND500
X_42_ RST_N _13_ COUNT_R[4] _16_ GROUND VDD ORND00
X_43_ _15_ _16_ _04_ VDD GROUND NOR200
X_44_ COUNT_R[0] COUNT_R[2] COUNT_R[1] COUNT_R[5] COUNT_R[4] COUNT_R[3] _17_ VDD GROUND NND600
X_45_ _15_ COUNT_R[5] _18_ GROUND VDD OR2100
X_46_ _18_ _17_ RST_N _05_ GROUND VDD AND300
X_47_ _09_ _19_ _17_ GROUND VDD XNR200
X_48_ _08_ _19_ _06_ VDD GROUND NOR200
X_49_ COUNT_R[7] _17_ _09_ _20_ GROUND VDD ORND00
X_50_ _09_ COUNT_R[7] _17_ _21_ GROUND VDD OR3100
X_51_ _21_ _20_ _08_ _07_ VDD GROUND ADNR00
X_52_ CLKNET_1_1__LEAF_CLK _00_ _29_[0] COUNT_R[0] GROUND VDD DFFL11
X_53_ CLKNET_1_1__LEAF_CLK _01_ _28_ COUNT_R[1] GROUND VDD DFFL11
X_54_ CLKNET_1_1__LEAF_CLK _02_ _27_ COUNT_R[2] GROUND VDD DFFL11
X_55_ CLKNET_1_1__LEAF_CLK _03_ _26_ COUNT_R[3] GROUND VDD DFFL11
X_56_ CLKNET_1_0__LEAF_CLK _04_ _25_ COUNT_R[4] GROUND VDD DFFL11
X_57_ CLKNET_1_0__LEAF_CLK _05_ _24_ COUNT_R[5] GROUND VDD DFFL11
X_58_ CLKNET_1_0__LEAF_CLK _06_ _23_ COUNT_R[6] GROUND VDD DFFL11
X_59_ CLKNET_1_0__LEAF_CLK _07_ _22_ COUNT_R[7] GROUND VDD DFFL11
XCLKBUF_0_CLK CLK CLKNET_0_CLK GROUND VDD INVR00
XCLKBUF_1_0__F_CLK CLKNET_0_CLK CLKNET_1_0__LEAF_CLK GROUND VDD INVR00
XCLKBUF_1_1__F_CLK CLKNET_0_CLK CLKNET_1_1__LEAF_CLK GROUND VDD INVR00

.ENDS CNT8_TOP
